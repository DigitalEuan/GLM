* ============================================================
* Op-amp + analog multiplier square root extractor
* Generated by the cent compiler
*
* £:  V_out = sqrt(V_in)
* ¢:  scale(V_in, 1) -> div(_, 1) -> sqrt(_) -> V_out
*     (degenerates to: V_out^2 = V_in, solved by feedback)
* ∆:  op-amp (U1) + analog multiplier (U2) in feedback loop
*
* Equilibrium: V_out^2 / 10 = V_in  ->  V_out = sqrt(10 * V_in)
* With V_in = 5.0V: V_out = sqrt(50.0) = 7.071068V
* ============================================================

VIN 1 0 DC 5.0
EOUT 3 0 1 2 1e6
EMULT 4 0 VALUE = { V(3) * V(3) / 10.0 }
R1 4 2 1k
Rg 2 0 1meg
.OP
.PRINT DC V(3)
.END
