* Machine concept: MACHINE: Y_out(t) ≈ √2
* This is a declared core bundle, not a fabrication netlist.
* It is not a measured device or a mixed-signal simulation.
* ============================================================
* Delta-Sigma modulator (first-order)
* Generated by the cent compiler
*
* £:  Q(t) = ∫I(t)dt  (temporal integration)
* ¢:  accum(I) -> wrap(quantizer) -> eq(feedback)
* ∆:  delta-sigma modulator (digital, temporal carrier)
*
* Input: I = 0.700035713374682 (constant)
* Samples: 100000
* Expected: running_sum(bitstream) -> 70003.5713374682
* ============================================================

* This is a behavioral model — real delta-sigma requires
* a mixed-signal simulator (e.g., Verilog-AMS).
* The Python simulation in simulator.py provides the
* bitstream-level verification.

VIN 1 0 DC 0.700035713374682
* Integrator (op-amp + capacitor)
EINT 2 0 VALUE = { 0 } ; behavioral integrator
* Quantizer (comparator)
EQUANT 3 0 VALUE = { IF(V(2)>0, 1, -1) }
* Feedback
RFB 3 2 1k
CINT 2 0 1u
.OP
.PRINT DC V(3)
.END
