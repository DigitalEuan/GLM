* ============================================================
* AD633 Analog Multiplier (real component, no cancelling gain)
* Generated by the cent compiler
*
* £:  F = P × A  (force = pressure × area)
* ¢:  mult(P, A) → F
* ∆:  AD633 analog multiplier
*
* IMPORTANT: The AD633 output is V(3) = V(1)*V(2)/10, NOT V(1)*V(2).
* The /10 is the REAL AD633 scale factor (datasheet, not a bug).
* We do NOT add a *10 gain stage — that would be tautological.
* The test compares V(3) to expected = P*A/10.
*
* Physical error sources (per AD633JN datasheet):
*   Nonlinearity: ±0.5% typical
*   Bandwidth: 1 MHz
*   Offset: ±50 mV
* ============================================================

VIN1 1 0 DC 1000.0
VIN2 2 0 DC 0.005

* AD633 subcircuit (simplified model with documented specs)
XU1 1 2 3 AD633
RLOAD 3 0 10k

.SUBCKT AD633 X Y Z
* V(Z) = V(X) * V(Y) / 10  (AD633 transfer function, datasheet pg 3)
* Nonlinearity not modeled in .OP (nominal value only)
EMULT Z 0 VALUE = { V(X) * V(Y) / 10.0 }
.ENDS

* Analysis: DC operating point
.OP
.PRINT DC V(3)

* Sweep 3 input pairs (run separately or use .STEP):
* Pair 1: P=1000, A=0.005 → expected V(3) = 0.500
* Pair 2: P=500,  A=0.01  → expected V(3) = 0.500
* Pair 3: P=2000, A=0.002 → expected V(3) = 0.400

* Measure equilibrium error
.MEASURE DC vout PARAM='V(3)'
.MEASURE DC expected PARAM='1000.0 * 0.005 / 10.0'
.MEASURE DC error_pct PARAM='abs(V(3) - 1000.0 * 0.005 / 10.0) / (1000.0 * 0.005 / 10.0) * 100'

* Behavioral model note: This .cir uses a behavioral EMULT source for
* mathematical verification. Physical validation (with nonlinearity,
* parasitics, temperature drift) requires ngspice/LTspice with the
* full AD633 macro-model from Analog Devices.

.END
