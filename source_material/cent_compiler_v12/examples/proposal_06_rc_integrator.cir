* ============================================================
* RC integrator (capacitor-based temporal integration)
* Generated by the cent compiler
*
* £:  V_out(t) = (1/RC) · ∫V_in(t)dt
* ¢:  accum(V_in) -> scale(1/RC) -> V_out
* ∆:  resistor + capacitor (electrical, temporal carrier)
* ============================================================

VIN 1 0 DC 1.0
R1 1 2 1000
C1 2 0 1e-06
.IC V(2) = 0
.TRAN 1u 1m
.PRINT TRAN V(2)
.END
